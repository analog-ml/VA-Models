// *  BSIM-CMG 112.0.0beta4 released on 11/08/2024                            *
// *  BSIM Common Multi-Gate Model (Verilog-A)                                *
// ****************************************************************************

// ****************************************************************************
// *  Copyright © 2024 University of California                               *
// *                                                                          *
// *  Project director: Prof. Sayeef Salahuddin                               *
// *                    Prof. Chenming Hu                                     *
// *                                                                          *
// *  Developers: https://www.bsim.berkeley.edu/models/bsimcmg/auth_cmg/      *
// ****************************************************************************

`include "constants.vams"
`include "disciplines.vams"
`include "bsimcmg_macros.include"
module bsimcmg_va(d, g, s, e, t);
    inout d, g, s, e, t;
    electrical d, g, s, e;
    electrical di, si, di1, si1;
    electrical ge, gi;
    electrical q;
    electrical n;
    thermal t;
    `include "bsimcmg_parameters.include"
    `include "bsimcmg_variables.include"
    `include "bsimcmg_body.include"
endmodule
